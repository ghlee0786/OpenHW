* SIM-B3 TPS54302 루프 이득 (직렬 주입, 1.3 A)

.subckt TPS54302 vin sw fb params: L=10u FSW=400k
Vuv uv 0 1
Vss ss 0 0.596
Gea 0 comp VALUE = { 0.00024 * (min(v(ss), 0.596) - v(fb)) }
* EA 출력 클램프 (6.3.1): 0 ~ I(LIM_HS)/Gcs 밖으로 나가면 1 mS 로 되돌림 (연속 함수 — 수렴용)
Bclp comp 0 I = 1e-3 * (max(v(comp) - 0.35711, 0) + min(v(comp), 0))
Rc comp cz 20000.0
Cc cz 0 2.04e-09
Cp comp 0 2e-12
Rcl comp 0 10Meg
* 전류 명령 → fsw/2 2차 지연 (평균 전류 모드 샘플링 근사)
Bcmd cmd 0 V = (v(fb) > 0.64368 ? 0 : 1) * max(0, min(11.2011 * v(comp), 4.0 - (v(vin) - v(sw)) * v(sw) / (v(vin) + 1e-3) / ({L} * {FSW}) / 2))
Rf1 cmd f1 1
Lf1 f1 f2 {0.64 / (3.14159 * FSW)}
Cf1 f2 0 {1 / (0.64 * 3.14159 * FSW)}
* 인덕터 전류 (전압 노드 il = 암페어), 기울기 제한
Eil il 0 f2 0 1
Gout 0 sw VALUE = { max(v(il), 0) }
Bin vin 0 I = max(v(il), 0) * v(sw) / max(v(vin), 1) / 0.92
.ends

Vin vin 0 12.0
X1 vin sw fb TPS54302 params: L=1e-05 FSW=400000.0
Cout sw ce 6.993e-05
Resr ce 0 2m
Rtop vs fb 78700
Rbot fb 0 10700
Cff vs fb 75p
Vinj sw vs DC 0 AC 1
Ild sw 0 1.3
.nodeset v(sw)=5.0 v(vs)=5.0 v(fb)=0.596 v(x1.ss)=0.596 v(x1.uv)=1 v(x1.il)=1.3 v(x1.f2)=1.3 v(x1.f1)=1.3 v(x1.cmd)=1.3 v(x1.comp)=0.11606 v(x1.cz)=0.11606
.control
set wr_singlescale
set wr_vecnames
ac dec 50 100 200k
let T = -v(sw)/v(vs)
let tm = mag(T)
let tp = cph(T)
wrdata b3ac.dat tm tp
quit
.endc
.end

* SIM-001b
.model dsi D(IS=1e-14 N=1)
.model bat54 D(IS=2e-7 N=1.05 RS=1.5 CJO=10p)
.model nq nmos level=1 vto=1.0 kp=1.79
.model pa pmos level=1 vto=-1.3 kp=10
V33s v33s 0 3.3
R33 v33s v33 0.1
C33 v33 0 22u
Ven e0 0 PWL(0 0 0.001 0 0.001001 1.71 0.006 1.71 0.006001 0)
Ren e0 en 93.75
R6 en 0 100k
R7 en rst 10k
C10 rst 0 100n
D3 rst en bat54
M3 pg en 0 0 nq
Cg3 en 0 61p
R4 v33 pg 100k
R20 pg pgio 100k
R21 pgio d4a 1k
D4 d4a pg bat54
M1 iov g1i v33 v33 pa
Rg1 pgio g1i 7.8
Cgs1 g1i v33 590p
Cgd1 g1i iov 55p
C20 pgio iov 4.7n
Db1 iov v33 dsi
R5 pg pgav 100k
D5 pg pgav bat54
M2 avd g2i v33 v33 pa
Rg2 pgav g2i 7.8
Cgs2 g2i v33 590p
Cgd2 g2i avd 55p
C21 pgav avd 4.7n
Db2 avd v33 dsi
C7 iov 0 1u
Rli iov 0 79.51807228915662
C8 avd 0 1u
C9 avd 0 100n
Rla avd 0 183.33333333333334

.options reltol=1e-3 abstol=1e-9 vntol=1e-6 itl4=200
.tran 50n 40m 0 2u uic
.control
set wr_singlescale
set wr_vecnames
run
wrdata out.txt v(en) v(rst) v(iov) v(avd) v(v33) i(V33s)
quit
.endc
.end

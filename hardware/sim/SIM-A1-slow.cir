* SIM-A1 TPS26600 기동 돌입 (slow 코너) — 캐리어 U2, C9 dVdT, 출력 C = C11 + 전면 C14..C17

.subckt TPS26600 in out shdn dvdt
* 켜짐 조건 (POR 상승 4.1 V 최악, OVP 상승 31.0 V 최악 — 히스테리시스는 A2 에서 따로)
Ben en0 0 V = (v(shdn) > 0.76) && (v(in) > 4.1) && (v(in) < 31.0) && (v(flt) < 0.5) ? 1 : 0
Ren en0 en 1k
Cen en 0 1n
* dVdT: 켜지면 I(dVdT) 충전, 꺼지면 14 Ω 방전
Bdv 0 dvdt I = v(en) > 0.5 ? (4e-06 * (v(dvdt) * 23.75 < v(in) + 1 ? 1 : 0)) : -v(dvdt) / 14.0
* 통과 FET: 목표 = min(GAIN·VdVdT, VIN), 전류 = (목표 − OUT)/RON, 0 ~ I(OL) 로 제한
Bfet in out I = v(en) > 0.5 ? max(0, min(1.87947, (min(23.75 * v(dvdt), v(in)) - v(out)) / 0.15)) : 0
* 회로차단기 타이머: 제한 중이면 1 V / 4 ms 로 오르고, 아니면 빨리 내림. 1 V 넘으면 flt 래치
Blim lim 0 V = ((min(23.75 * v(dvdt), v(in)) - v(out)) / 0.15 > 1.87007) && (v(en) > 0.5) ? 1 : 0
Btm 0 tmr I = v(lim) > 0.5 ? (v(tmr) < 1.2 ? 0.00025 : 0) : (v(tmr) > 0 ? -1e-4 : 0)
Ctm tmr 0 1u
Bfl 0 flt I = v(tmr) > 1 ? max(0, 1 - v(flt)) : (v(flt) > 0 ? -9.25926e-07 : 0)
Cfl flt 0 1u
.ends

Vin in 0 11.4
Vsh shdn 0 PULSE(0 1.8 1m 10u 10u 1 2)
X1 in out shdn dvdt TPS26600
Cdv dvdt 0 2.42e-08
Cout out 0 2.718e-05
Rbl out 0 100k
.control
set wr_singlescale
set wr_vecnames
tran 2u 15m uic
wrdata a1_slow.dat v(out) i(Vin)
quit
.endc
.end
